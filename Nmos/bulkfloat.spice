*** Nmos ***

.param W=5, L=0.30

.lib "/usr/local/share/pdk/share/pdk/sky130A/libs.tech/ngspice/sky130.lib.spice" tt

* Voltage sources
Vgs Vgs 0 DC 0.9
Vds Vdd 0 DC 0.2
Vs  Vs  0 DC 0
Vsb Vb  0 DC 0
Xfet1 Vdd Vgs Vs Vb MY_NFET

.subckt MY_NFET Vd Vg Vs Vb
   XMN Vd Vg Vs Vb sky130_fd_pr__nfet_01v8 w=W l=L nf=1 ad=1.45 as=1.45 pd=10.58 ps=10.58 nrd=0.058 nrs=0.058 sa=0 sb=0 sd=0 mult=1
.ends MY_NFET

.control
    destroy all
    op
    let gm = @m.xfet1.xmn.msky130_fd_pr__nfet_01v8[gm]
    let gmb = @m.xfet1.xmn.msky130_fd_pr__nfet_01v8[gmbs]
    let gds = @m.xfet1.xmn.msky130_fd_pr__nfet_01v8[gds]
    let Vth = @m.xfet1.xmn.msky130_fd_pr__nfet_01v8[vth]
    print all

.endc

.end
